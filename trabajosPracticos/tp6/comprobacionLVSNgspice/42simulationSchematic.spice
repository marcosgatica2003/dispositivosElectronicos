** sch_path: /home/marcosgatica/facultadUTN/dispositivosElectronicos/trabajosPracticos/tp6/archivosXschem/42simulation.sch

.include /home/marcosgatica/pdk/sky130B/libs.ref/sky130_fd_sc_hd/spice/sky130_fd_sc_hd.spice

**.subckt 42simulation
V1 net1 GND 1.8
V2 vin GND PULSE(0 1.8 0 1n 1n 5n 10n 4)
XR1 GND vout GND sky130_fd_pr__res_iso_pw W=2.65 L=2.65 m=1
x1 net1 vin vout GND 41schematicDesignActividad2
**** begin user architecture code
.lib /home/marcosgatica/pdk/sky130B/libs.tech/ngspice/sky130.lib.spice tt

.control
	run
	tran 0.5n 40n
	write std_not4_tb.raw
.endc
.save all

**** end user architecture code
**.ends

* expanding   symbol:
*+  /home/marcosgatica/facultadUTN/dispositivosElectronicos/trabajosPracticos/tp6/archivosXschem/41schematicDesignActividad2.sym # of pins=4
** sym_path: /home/marcosgatica/facultadUTN/dispositivosElectronicos/trabajosPracticos/tp6/archivosXschem/41schematicDesignActividad2.sym
** sch_path: /home/marcosgatica/facultadUTN/dispositivosElectronicos/trabajosPracticos/tp6/archivosXschem/41schematicDesignActividad2.sch
.subckt 41schematicDesignActividad2 Vdd Vin Vout VSS
*.ipin Vdd
*.ipin Vin
*.ipin VSS
*.opin Vout
XM1 Vout Vin VSS VSS sky130_fd_pr__nfet_01v8 L=0.15 W=1.05 nf=1 ad='int((nf+1)/2) * W/nf * 0.29' as='int((nf+2)/2) * W/nf * 0.29' pd='2*int((nf+1)/2) * (W/nf + 0.29)'
+ ps='2*int((nf+2)/2) * (W/nf + 0.29)' nrd='0.29 / W' nrs='0.29 / W' sa=0 sb=0 sd=0 mult=1 m=1
XM2 Vout Vin Vdd Vdd sky130_fd_pr__pfet_01v8 L=0.15 W=2.1 nf=1 ad='int((nf+1)/2) * W/nf * 0.29' as='int((nf+2)/2) * W/nf * 0.29' pd='2*int((nf+1)/2) * (W/nf + 0.29)'
+ ps='2*int((nf+2)/2) * (W/nf + 0.29)' nrd='0.29 / W' nrs='0.29 / W' sa=0 sb=0 sd=0 mult=1 m=1
.ends

.GLOBAL GND
.end
